// VerilogA for CNTFET, NCNFET, veriloga

/*******************************************************************
 Carbon Nanotube Field Effect Transistors
             VerilogA Models
	       Version 2.1.1

   Copyright The Board Trustees of the Leland Stanford Junior University 2007
   Albert Lin, Gordon Wan, Jie Deng, Prof. H-S Philip Wong

   02/02/2008 Last Modified by Albert Lin.

   Carbon Nanotube Field Effect Transistors Verilog-A implementation
   based on
   "A Circuit-Compatible SPICE model for Enhancement Mode Carbon
   Nanotube Field Effect Transistors" by Jie Deng and H-S Philip Wong

   Patent Pending.

   Model name: NCNFET.va
*******************************************************************/

/*******************************************************************
* TERMS OF USE
* Stanford Leland Junior University and the authors ("Stanford")
* provide these model files to you subject to the Terms of Use,
* which may be updated by us from time to time without notice to you.
* The most up-to-date Terms of Use can be found at
* http://www.stanford.edu/group/nanoelectronics/model_downloads.htm
*******************************************************************/

/*******************************************************************
* Standard Models:
* This model accounts for charge-screening effects among
* multiple tubes within the same FET device by
* differentiating between tubes at the edge, which are affected by
* one neighboring tube, and tubes in the middle, which are affected
* by two neighboring tubes.
*
* No 'CNTPos' param is used.
*******************************************************************/
/*******************************************************************
*
* N-CNFET Level 3 Sub-circuit Definition
* (Top Level Standard Model)
*******************************************************************/
`include "disciplines.vams"
`include "NCNFET_L2.va"

module NCNFET(Drain,Gate,Source,Sub);

      	// Input variables definitions
    	parameter real Lch=`L_channel;
    	parameter real Lgeff = `Lceff;
    	parameter real Lss=`L_sd;
    	parameter real Ldd=`L_sd;
    	parameter real Efi=`Efo;
    	parameter real Kgate=`Kox;
    	parameter real Tox=4.0e-9;
    	parameter real Csub=20.0e-12;
    	parameter real Ccsd=`Ccsd;
    	parameter real CoupleRatio=`CoupleRatio;
    	parameter real Vfbn=0.0;
    	parameter real Dout=1.0;
    	parameter real Sout=0.0;
	parameter real Pitch=20.0e-9;
    	parameter real Wgate=`sub_pitch;
    	parameter real CNTPos=1.0; //not used
    	parameter real n1=19;
    	parameter real n2=0;
	parameter real tubes=1.0;

    	// Electrical connections
    	inout Drain, Gate, Source, Sub;
    	electrical Drain, Gate, Source, Sub;

    	electrical int_Drain1, int_Gate1, int_Source1; //For XNCNFET_L2_edge with CNTPos=1
    	electrical int_Drain0, int_Gate0, int_Source0; //FOR XNCNFET_L2_midd with CNTPos=0

	/***********************************************************
     	*** Component values to be computed heavily ****************
     	***********************************************************/
	real Cgpar;

	//HSPICE uses the 'm' parameter.
	//Here, probes are used along with CCCS to multiply all currents.

	//Model edge tubes: probe the currents going into 1 instance
	branch (Drain, int_Drain1) probe_drain1;
	branch (Gate, int_Gate1) probe_gate1;
	branch (Source, int_Source1) probe_source1;

	NCNFET_L2 #(.Lch(Lch),.Lgeff(Lgeff),.Lss(Lss),.Ldd(Ldd),.Efi(Efi),.Kgate(Kgate),.Tox(Tox),.Csub(Csub),.Ccsd(Ccsd),.CoupleRatio(CoupleRatio),.Vfbn(Vfbn),.Dout(Dout),.Sout(Sout),.GF(min(Wgate/1.0e-12,1.0)),.Pitch(Pitch),.CNTPos(1),.n1(n1),.n2(n2)) XNCNFET_L2_edge (int_Drain1, int_Gate1, int_Source1, Sub, int_Drain1);

	//Model the middle tubes: probe the currents going into 1 instance
	branch (Drain, int_Drain0) probe_drain0;
	branch (Gate, int_Gate0) probe_gate0;
	branch (Source, int_Source0) probe_source0;

    	NCNFET_L2 #(.Lch(Lch),.Lgeff(Lgeff),.Lss(Lss),.Ldd(Ldd),.Efi(Efi),.Kgate(Kgate),.Tox(Tox),.Csub(Csub),.Ccsd(Ccsd),.CoupleRatio(CoupleRatio),.Vfbn(Vfbn),.Dout(Dout),.Sout(Sout),.GF(min(Wgate/1.0e-12,1.0)),.Pitch(Pitch),.CNTPos(0),.n1(n1),.n2(n2)) XNCNFET_L2_midd (int_Drain0, int_Gate0, int_Source0, Sub, int_Drain0);

	analog begin

		begin // Assign basic parameter
			Cgpar = `Ctot*Wgate;
		end

                //model the other (min(tubes,2)-1) edge tubes with CC-CS
		I(Drain, Sub)	<+	(min(tubes,2)-1)*I(probe_drain1);
		I(Gate, Sub)	<+	(min(tubes,2)-1)*I(probe_gate1);
		I(Source, Sub)	<+	(min(tubes,2)-1)*I(probe_source1);
	        //By KCL, the current on node Sub is also scaled automatically

	        //model the other (max(tubes-2,0)-1) middle tubes with CC-CS:
		I(Drain, Sub)	<+	(max(tubes-2,0)-1)*I(probe_drain0);
		I(Gate, Sub)	<+	(max(tubes-2,0)-1)*I(probe_gate0);
		I(Source, Sub)	<+	(max(tubes-2,0)-1)*I(probe_source0);
	        //By KCL, the current on node Sub is also scaled automatically

		// Placing component
        	// Capacitors
         	I(Gate,Sub)        <+ ddt(Cgpar*V(Gate,Sub));

    	end // End: analog begin
endmodule
